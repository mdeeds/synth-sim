* SSM2164 channel 1 current output into a TL072 capacitive-feedback integrator.
* Input is +/-5 V at 1 kHz; control voltage is held at +0.774 V.
.include ..\..\models\2164\SSM2164.lib
.include ..\..\models\tl072\TL072.lib

VCC VCC 0 15
VEE VEE 0 -15
VINPUT IN 0 PULSE(-5 5 0.25m 1n 1n 0.5m 1m)
RIN IN NDRIVE 30k
RSHUNT NDRIVE NCOMP 500
CCOMP NCOMP 0 560p
VIMON NDRIVE IIN1 0
VCV CV 0 0.774
VMODE MODE 0 0

VVC2 VC2 0 0
VIIN2 IIN2 0 0
VVC3 VC3 0 0
VIIN3 IIN3 0 0
VVC4 VC4 0 0
VIIN4 IIN4 0 0
VIOUT2 IOUT2 0 0
VIOUT3 IOUT3 0 0
VIOUT4 IOUT4 0 0
VOMON IOUT1 SUM 0
* SSM2164 datasheet pin order: 1 MODE, 2 IIN1, 3 VC1, 4 IOUT1, 5 IOUT2,
* 6 VC2, 7 IIN2, 8 GND, 9 VEE, 10 IIN3, 11 VC3, 12 IOUT3, 13 IOUT4,
* 14 VC4, 15 IIN4, 16 VCC.
XU1 MODE IIN1 CV IOUT1 IOUT2 VC2 IIN2 0 VEE IIN3 VC3 IOUT3 IOUT4 VC4 IIN4 VCC SSM2164

CFB OUT SUM 560p IC=0
* TL072 datasheet pin order: 1 OUT1, 2 IN1-, 3 IN1+, 4 VEE, 5 IN2+,
* 6 IN2-, 7 OUT2, 8 VCC.
XU2 OUT SUM 0 VEE 0 0 OUTB VCC TL072

.save V(IN) V(CV) V(SUM) V(OUT) V(IOUT1) I(VIMON) I(VOMON)
.tran 0 2m 0 100n uic
.meas tran OUT_MIN MIN V(OUT) FROM=1m TO=2m
.meas tran OUT_MAX MAX V(OUT) FROM=1m TO=2m
.meas tran OUT_PP PARAM OUT_MAX-OUT_MIN
.options TNOM=25 TEMP=25
.end

* J111-D Figure 10 simulation using the shared J111 subcircuit model.
* The family members span the datasheet's plotted IDSS and VGS(off) ranges.
.include ..\J111.lib

VGS G 0 0

VLO10 DLO10 0 0.1
V5_10 D5_10 0 5
V15_10 D15_10 0 15
X10 DLO10 G 0 J111 PARAMS: VTO=-1.1 BETA=8.264m
X5_10 D5_10 G 0 J111 PARAMS: VTO=-1.1 BETA=8.264m
X15_10 D15_10 G 0 J111 PARAMS: VTO=-1.1 BETA=8.264m

VLO20 DLO20 0 0.1
V5_20 D5_20 0 5
V15_20 D15_20 0 15
X20 DLO20 G 0 J111 PARAMS: VTO=-1.9 BETA=5.540m
X5_20 D5_20 G 0 J111 PARAMS: VTO=-1.9 BETA=5.540m
X15_20 D15_20 G 0 J111 PARAMS: VTO=-1.9 BETA=5.540m

VLO30 DLO30 0 0.1
V5_30 D5_30 0 5
V15_30 D15_30 0 15
X30 DLO30 G 0 J111 PARAMS: VTO=-2.5 BETA=4.800m
X5_30 D5_30 G 0 J111 PARAMS: VTO=-2.5 BETA=4.800m
X15_30 D15_30 G 0 J111 PARAMS: VTO=-2.5 BETA=4.800m

VLO40 DLO40 0 0.1
V5_40 D5_40 0 5
V15_40 D15_40 0 15
X40 DLO40 G 0 J111 PARAMS: VTO=-3.0 BETA=4.444m
X5_40 D5_40 G 0 J111 PARAMS: VTO=-3.0 BETA=4.444m
X15_40 D15_40 G 0 J111 PARAMS: VTO=-3.0 BETA=4.444m

VLO50 DLO50 0 0.1
V5_50 D5_50 0 5
V15_50 D15_50 0 15
X50 DLO50 G 0 J111 PARAMS: VTO=-3.5 BETA=4.082m
X5_50 D5_50 G 0 J111 PARAMS: VTO=-3.5 BETA=4.082m
X15_50 D15_50 G 0 J111 PARAMS: VTO=-3.5 BETA=4.082m

VLO60 DLO60 0 0.1
V5_60 D5_60 0 5
V15_60 D15_60 0 15
X60 DLO60 G 0 J111 PARAMS: VTO=-4.0 BETA=3.750m
X5_60 D5_60 G 0 J111 PARAMS: VTO=-4.0 BETA=3.750m
X15_60 D15_60 G 0 J111 PARAMS: VTO=-4.0 BETA=3.750m

VLO70 DLO70 0 0.1
V5_70 D5_70 0 5
V15_70 D15_70 0 15
X70 DLO70 G 0 J111 PARAMS: VTO=-4.5 BETA=3.457m
X5_70 D5_70 G 0 J111 PARAMS: VTO=-4.5 BETA=3.457m
X15_70 D15_70 G 0 J111 PARAMS: VTO=-4.5 BETA=3.457m

VLO80 DLO80 0 0.1
V5_80 D5_80 0 5
V15_80 D15_80 0 15
X80 DLO80 G 0 J111 PARAMS: VTO=-5.1 BETA=3.076m
X5_80 D5_80 G 0 J111 PARAMS: VTO=-5.1 BETA=3.076m
X15_80 D15_80 G 0 J111 PARAMS: VTO=-5.1 BETA=3.076m

VLO90 DLO90 0 0.1
V5_90 D5_90 0 5
V15_90 D15_90 0 15
X90 DLO90 G 0 J111 PARAMS: VTO=-5.8 BETA=2.675m
X5_90 D5_90 G 0 J111 PARAMS: VTO=-5.8 BETA=2.675m
X15_90 D15_90 G 0 J111 PARAMS: VTO=-5.8 BETA=2.675m

VLO100 DLO100 0 0.1
V5_100 D5_100 0 5
V15_100 D15_100 0 15
X100 DLO100 G 0 J111 PARAMS: VTO=-6.5 BETA=2.367m
X5_100 D5_100 G 0 J111 PARAMS: VTO=-6.5 BETA=2.367m
X15_100 D15_100 G 0 J111 PARAMS: VTO=-6.5 BETA=2.367m

VLO110 DLO110 0 0.1
V5_110 D5_110 0 5
V15_110 D15_110 0 15
X110 DLO110 G 0 J111 PARAMS: VTO=-7.3 BETA=2.064m
X5_110 D5_110 G 0 J111 PARAMS: VTO=-7.3 BETA=2.064m
X15_110 D15_110 G 0 J111 PARAMS: VTO=-7.3 BETA=2.064m

VLO120 DLO120 0 0.1
V5_120 D5_120 0 5
V15_120 D15_120 0 15
X120 DLO120 G 0 J111 PARAMS: VTO=-8.5 BETA=1.661m
X5_120 D5_120 G 0 J111 PARAMS: VTO=-8.5 BETA=1.661m
X15_120 D15_120 G 0 J111 PARAMS: VTO=-8.5 BETA=1.661m

VLO130 DLO130 0 0.1
V5_130 D5_130 0 5
V15_130 D15_130 0 15
X130 DLO130 G 0 J111 PARAMS: VTO=-10 BETA=1.300m
X5_130 D5_130 G 0 J111 PARAMS: VTO=-10 BETA=1.300m
X15_130 D15_130 G 0 J111 PARAMS: VTO=-10 BETA=1.300m

.save V(G) I(VLO10) I(V5_10) I(V15_10) I(VLO20) I(V5_20) I(V15_20)
.save I(VLO30) I(V5_30) I(V15_30) I(VLO40) I(V5_40) I(V15_40)
.save I(VLO50) I(V5_50) I(V15_50) I(VLO60) I(V5_60) I(V15_60)
.save I(VLO70) I(V5_70) I(V15_70) I(VLO80) I(V5_80) I(V15_80)
.save I(VLO90) I(V5_90) I(V15_90) I(VLO100) I(V5_100) I(V15_100)
.save I(VLO110) I(V5_110) I(V15_110) I(VLO120) I(V5_120) I(V15_120)
.save I(VLO130) I(V5_130) I(V15_130)
.dc VGS 0 -12 -0.01
.options TNOM=25 TEMP=25
.end

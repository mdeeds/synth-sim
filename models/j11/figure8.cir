* J111-D datasheet Figure 8 reproduction
* The datasheet curves are typical family curves at Tchannel = 25 C.
* Each instance uses its own fitted VTO/BETA pair to reproduce the labeled curve.
.include J111.lib

VGS G 0 0
VDS10 D10 0 0.1
VDS25 D25 0 0.1
VDS50 D50 0 0.1
VDS75 D75 0 0.1
VDS100 D100 0 0.1
VDS125 D125 0 0.1
VDSJ111_ON DJ111_ON 0 0.1
VDSJ111_IDSS DJ111_IDSS 0 15

X10 D10 G 0 J111 PARAMS: VTO=-1.55 BETA=4.9m
X25 D25 G 0 J111 PARAMS: VTO=-2.20 BETA=5.2m
X50 D50 G 0 J111 PARAMS: VTO=-3.30 BETA=4.2m
X75 D75 G 0 J111 PARAMS: VTO=-4.40 BETA=3.9m
X100 D100 G 0 J111 PARAMS: VTO=-5.40 BETA=3.8m
X125 D125 G 0 J111 PARAMS: VTO=-7.05 BETA=3.7m
XJ111_ON DJ111_ON G 0 J111
XJ111_IDSS DJ111_IDSS G 0 J111

.save V(G) I(VDS10) I(VDS25) I(VDS50) I(VDS75) I(VDS100) I(VDS125) I(VDSJ111_ON) I(VDSJ111_IDSS)
.dc VGS 0 -7 -0.05
.options TNOM=25 TEMP=25
.end

* LM393 comparator threshold/polarity test, 5 V supply and 10 kOhm pull-up.
.include ..\LM393.lib
VCC VCC 0 5
VIN INP 0 0
VREF REF 0 2.5
RPU OUT VCC 10k
RPUB OUTB VCC 10k
* LM393 datasheet pin order: 1 OUT1, 2 IN1-, 3 IN1+, 4 VEE, 5 IN2+,
* 6 IN2-, 7 OUT2, 8 VCC.
XU1 OUT REF INP 0 REF INP OUTB VCC LM393
.dc VIN 0 3.5 0.01
.options TNOM=25 TEMP=25
.end
